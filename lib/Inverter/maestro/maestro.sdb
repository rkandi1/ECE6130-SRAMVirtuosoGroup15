ADE simulation setup
Run mode: Single Run, Sweeps and Corners
Tests:
  NCSU_Devices_FreePDK45_myInverter_1: NCSU_Devices_FreePDK45/myInverter/schematic, simulator spectre
