ADE simulation setup
Test NCSU_Devices_FreePDK45_myInverter_1: NCSU_Devices_FreePDK45/myInverter/schematic, simulator spectre
  Models: /nethome/shossain49/ECE6130_Updated/ECE6130_LAB/Hspice/INC/NMOS_THKOX.inc, /nethome/shossain49/ECE6130_Updated/ECE6130_LAB/Hspice/INC/NMOS_VTG.inc, /nethome/shossain49/ECE6130_Updated/ECE6130_LAB/Hspice/INC/NMOS_VTH.inc, /nethome/shossain49/ECE6130_Updated/ECE6130_LAB/Hspice/INC/NMOS_VTL.inc, /nethome/shossain49/ECE6130_Updated/ECE6130_LAB/Hspice/INC/PMOS_THKOX.inc, /nethome/shossain49/ECE6130_Updated/ECE6130_LAB/Hspice/INC/PMOS_VTG.inc, /nethome/shossain49/ECE6130_Updated/ECE6130_LAB/Hspice/INC/PMOS_VTH.inc, /nethome/shossain49/ECE6130_Updated/ECE6130_LAB/Hspice/INC/PMOS_VTL.inc
  Temperature: 27
  Analysis tran: stop=4n
