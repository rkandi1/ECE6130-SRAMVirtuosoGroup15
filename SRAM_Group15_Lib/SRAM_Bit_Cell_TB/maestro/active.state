ADE simulation setup
Test SRAM_Group15_Lib_SRAM_Bit_Cell_TB_1: SRAM_Group15_Lib/SRAM_Bit_Cell_TB/schematic, simulator spectre
  Models: /nethome/umunj3/ECE6130_Updated/ECE6130_LAB/Hspice/INC/NMOS_THKOX.inc, /nethome/umunj3/ECE6130_Updated/ECE6130_LAB/Hspice/INC/NMOS_VTG.inc, /nethome/umunj3/ECE6130_Updated/ECE6130_LAB/Hspice/INC/NMOS_VTH.inc, /nethome/umunj3/ECE6130_Updated/ECE6130_LAB/Hspice/INC/NMOS_VTL.inc, /nethome/umunj3/ECE6130_Updated/ECE6130_LAB/Hspice/INC/PMOS_THKOX.inc, /nethome/umunj3/ECE6130_Updated/ECE6130_LAB/Hspice/INC/PMOS_VTG.inc, /nethome/umunj3/ECE6130_Updated/ECE6130_LAB/Hspice/INC/PMOS_VTH.inc, /nethome/umunj3/ECE6130_Updated/ECE6130_LAB/Hspice/INC/PMOS_VTL.inc
  Variables: S1 = 1.5; S2 = 2; vin = 0; W = 90n
  Temperature: 27
  Analysis dc: sweep vin start=0 stop=0.8 step=0.01
  Signals: /net3, /TQB
