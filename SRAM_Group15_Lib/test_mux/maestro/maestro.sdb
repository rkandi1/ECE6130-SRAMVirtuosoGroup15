ADE simulation setup
Run mode: Single Run, Sweeps and Corners
Tests:
  SRAM_Group15_Lib_test_1: SRAM_Group15_Lib/test_mux/schematic, simulator spectre
