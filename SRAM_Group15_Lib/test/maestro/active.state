ADE simulation setup
Test SRAM_Group15_Lib_test_1: SRAM_Group15_Lib/test/schematic, simulator spectre
  Models: /nethome/shossain49/ECE6130_Updated/ECE6130_LAB/Hspice/INC/NMOS_THKOX.inc, /nethome/shossain49/ECE6130_Updated/ECE6130_LAB/Hspice/INC/NMOS_VTG.inc, /nethome/shossain49/ECE6130_Updated/ECE6130_LAB/Hspice/INC/NMOS_VTH.inc, /nethome/shossain49/ECE6130_Updated/ECE6130_LAB/Hspice/INC/NMOS_VTL.inc, /nethome/shossain49/ECE6130_Updated/ECE6130_LAB/Hspice/INC/PMOS_THKOX.inc, /nethome/shossain49/ECE6130_Updated/ECE6130_LAB/Hspice/INC/PMOS_VTG.inc, /nethome/shossain49/ECE6130_Updated/ECE6130_LAB/Hspice/INC/PMOS_VTH.inc, /nethome/shossain49/ECE6130_Updated/ECE6130_LAB/Hspice/INC/PMOS_VTL.inc
  Variables: tdelay = 0p:2p:50p
  Temperature: 27
  Analysis tran: stop=4n
Run mode: Single Run, Sweeps and Corners
