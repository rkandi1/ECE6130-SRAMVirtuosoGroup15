ADE simulation setup
Test SRAM_Group15_Lib_sram_tb_top_al_1: SRAM_Group15_Lib/sram_tb_top_al/schematic, simulator spectre
  Models: /nethome/rkandi3/ECE6130_Updated/ECE6130_LAB/Hspice/INC/NMOS_THKOX.inc, /nethome/rkandi3/ECE6130_Updated/ECE6130_LAB/Hspice/INC/NMOS_VTG.inc, /nethome/rkandi3/ECE6130_Updated/ECE6130_LAB/Hspice/INC/NMOS_VTH.inc, /nethome/rkandi3/ECE6130_Updated/ECE6130_LAB/Hspice/INC/NMOS_VTL.inc, /nethome/rkandi3/ECE6130_Updated/ECE6130_LAB/Hspice/INC/PMOS_THKOX.inc, /nethome/rkandi3/ECE6130_Updated/ECE6130_LAB/Hspice/INC/PMOS_VTG.inc, /nethome/rkandi3/ECE6130_Updated/ECE6130_LAB/Hspice/INC/PMOS_VTH.inc, /nethome/rkandi3/ECE6130_Updated/ECE6130_LAB/Hspice/INC/PMOS_VTL.inc
  Variables: C = 2.3
  Temperature: 27
  Analysis tran: stop=4n
  Signals: /I43/D7 (terminal), /I43/D6 (terminal), /I43/D5 (terminal), /I43/D4 (terminal), /I43/D3 (terminal), /I43/D2 (terminal), /I43/D1 (terminal), /I43/D0 (terminal), /I43/CLK (terminal), /I43/WEN (terminal), /I43/S0 (terminal), /I43/S1 (terminal), /I43/S2 (terminal), /I43/S3 (terminal), /I43/VDD (terminal), /I43/GND (terminal)
Run mode: Single Run, Sweeps and Corners
