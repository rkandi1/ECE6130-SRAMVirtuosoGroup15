ADE simulation setup
Test SRAM_Group15_Lib_sram_tb_top_al_1: SRAM_Group15_Lib/sram_tb_top_al/schematic, simulator spectre
  Models: /nethome/rkandi3/ECE6130_Updated/ECE6130_LAB/Hspice/INC/NMOS_THKOX.inc, /nethome/rkandi3/ECE6130_Updated/ECE6130_LAB/Hspice/INC/NMOS_VTG.inc, /nethome/rkandi3/ECE6130_Updated/ECE6130_LAB/Hspice/INC/NMOS_VTH.inc, /nethome/rkandi3/ECE6130_Updated/ECE6130_LAB/Hspice/INC/NMOS_VTL.inc, /nethome/rkandi3/ECE6130_Updated/ECE6130_LAB/Hspice/INC/PMOS_THKOX.inc, /nethome/rkandi3/ECE6130_Updated/ECE6130_LAB/Hspice/INC/PMOS_VTG.inc, /nethome/rkandi3/ECE6130_Updated/ECE6130_LAB/Hspice/INC/PMOS_VTH.inc, /nethome/rkandi3/ECE6130_Updated/ECE6130_LAB/Hspice/INC/PMOS_VTL.inc
  Variables: C = 2.3; mm = 0; Win = 360n; Wn = 360n; Wp = 270n; Wpc = 540n; Wt = 540n; VDD = 0.7 0.8 0.9 1.0; fclk = 1.0G
  Temperature: 27
  Analysis tran: stop=5n
  Output Ptotal = (VAR("VDD") * average(clip((IT("/I1/VDD") + IT("/I48/VDD")) (1 / VAR("fclk")) (5 / VAR("fclk")))))
  Output Q_end = value(VT("/I1/net13") (2.9 / VAR("fclk"))) (unticked)
  Output t_write = (cross(clip((VT("/I48/I0/R<15>/C<0>/net2") - VT("/I48/I0/R<15>/C<0>/net1")) (3 / VAR("fclk")) (4 / VAR("fclk"))) 0 1 "either") - cross(VT("/net11") (VAR("VDD") / 2) 3 "rising"))
  Output t_read = (cross(clip(VT("/I48/net31<7>") (2 / VAR("fclk")) (3 / VAR("fclk"))) (VAR("VDD") / 2) 1 "falling") - cross(VT("/net11") (VAR("VDD") / 2) 2 "rising"))
  Output p_vs_read = waveVsWave(?x t_read ?y Ptotal)
  Output p_vs_write = waveVsWave(?x t_write ?y Ptotal)
  Signals: /I48/WLR<0> (terminal), /I48/CS<0> (terminal), /I48/VDD (terminal), /I1/VDD (terminal), /net11 as CLK, /net12<0> as WL0, /VDD as VDD, /I48/I0/R<15>/C<0>/net1
Run mode: Single Run, Sweeps and Corners
