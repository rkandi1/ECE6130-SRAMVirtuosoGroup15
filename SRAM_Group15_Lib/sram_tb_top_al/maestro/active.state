ADE simulation setup
Test SRAM_Group15_Lib_sram_tb_top_al_1: SRAM_Group15_Lib/sram_tb_top_al/schematic, simulator spectre
  Models: /nethome/shossain49/ECE6130_Updated/ECE6130_LAB/Hspice/INC/NMOS_THKOX.inc, /nethome/shossain49/ECE6130_Updated/ECE6130_LAB/Hspice/INC/NMOS_VTG.inc, /nethome/shossain49/ECE6130_Updated/ECE6130_LAB/Hspice/INC/NMOS_VTH.inc, /nethome/shossain49/ECE6130_Updated/ECE6130_LAB/Hspice/INC/NMOS_VTL.inc, /nethome/shossain49/ECE6130_Updated/ECE6130_LAB/Hspice/INC/PMOS_THKOX.inc, /nethome/shossain49/ECE6130_Updated/ECE6130_LAB/Hspice/INC/PMOS_VTG.inc, /nethome/shossain49/ECE6130_Updated/ECE6130_LAB/Hspice/INC/PMOS_VTH.inc, /nethome/shossain49/ECE6130_Updated/ECE6130_LAB/Hspice/INC/PMOS_VTL.inc
  Temperature: 27
  Analysis tran: stop=4n
Run mode: Single Run, Sweeps and Corners
Setup values for test SRAM_Group15_Lib_sram_tb_top_al_1: C = 2.3
