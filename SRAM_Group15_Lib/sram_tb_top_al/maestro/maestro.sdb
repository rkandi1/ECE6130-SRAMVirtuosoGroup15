ADE simulation setup
Run mode: Single Run, Sweeps and Corners
Tests:
  SRAM_Group15_Lib_sram_tb_top_al_1: SRAM_Group15_Lib/sram_tb_top_al/schematic, simulator spectre
    Variables: C = 2.3; mm = 0; Win = 360n; Wn = 360n; Wp = 270n; Wpc = 540n; Wt = 540n; VDD = 0.7 0.8 0.9 1.0; fclk = 1.0G
    Outputs: BLM0; CLK; WL0; WL5; CS0; CS2; VDD; Ptotal; Q_write; Q_read; t_write; t_read; p_vs_read; p_vs_write
