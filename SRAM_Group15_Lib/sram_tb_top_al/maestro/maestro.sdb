ADE simulation setup
Run mode: Single Run, Sweeps and Corners
Tests:
  SRAM_Group15_Lib_sram_tb_top_al_1: SRAM_Group15_Lib/sram_tb_top_al/schematic, simulator spectre
    Variables: C = 2.3
