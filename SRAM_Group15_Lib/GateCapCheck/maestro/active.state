ADE simulation setup
Test SRAM_Group15_Lib_GateCapCheck_1: SRAM_Group15_Lib/GateCapCheck/schematic, simulator spectre
  Models: /nethome/rkandi3/ECE6130_Updated/ECE6130_LAB/Hspice/INC/NMOS_THKOX.inc, /nethome/rkandi3/ECE6130_Updated/ECE6130_LAB/Hspice/INC/NMOS_VTG.inc, /nethome/rkandi3/ECE6130_Updated/ECE6130_LAB/Hspice/INC/NMOS_VTH.inc, /nethome/rkandi3/ECE6130_Updated/ECE6130_LAB/Hspice/INC/NMOS_VTL.inc, /nethome/rkandi3/ECE6130_Updated/ECE6130_LAB/Hspice/INC/PMOS_THKOX.inc, /nethome/rkandi3/ECE6130_Updated/ECE6130_LAB/Hspice/INC/PMOS_VTG.inc, /nethome/rkandi3/ECE6130_Updated/ECE6130_LAB/Hspice/INC/PMOS_VTH.inc, /nethome/rkandi3/ECE6130_Updated/ECE6130_LAB/Hspice/INC/PMOS_VTL.inc
  Temperature: 27
  Analysis dc: (saves the operating point)
  Signals: /net1
Run mode: Single Run, Sweeps and Corners
