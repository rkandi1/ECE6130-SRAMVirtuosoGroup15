ADE simulation setup
Test SRAM_Group15_Lib_sram_tb_top_al_1: SRAM_Group15_Lib/sram_tb_top_al/schematic, simulator spectre
  Models: /nethome/rkandi3/ECE6130_Updated/ECE6130_LAB/Hspice/INC/NMOS_THKOX.inc, /nethome/rkandi3/ECE6130_Updated/ECE6130_LAB/Hspice/INC/NMOS_VTG.inc, /nethome/rkandi3/ECE6130_Updated/ECE6130_LAB/Hspice/INC/NMOS_VTH.inc, /nethome/rkandi3/ECE6130_Updated/ECE6130_LAB/Hspice/INC/NMOS_VTL.inc, /nethome/rkandi3/ECE6130_Updated/ECE6130_LAB/Hspice/INC/PMOS_THKOX.inc, /nethome/rkandi3/ECE6130_Updated/ECE6130_LAB/Hspice/INC/PMOS_VTG.inc, /nethome/rkandi3/ECE6130_Updated/ECE6130_LAB/Hspice/INC/PMOS_VTH.inc, /nethome/rkandi3/ECE6130_Updated/ECE6130_LAB/Hspice/INC/PMOS_VTL.inc
  Variables: C = 2.3; mm = 0; Win = 360n; Wn = 360n; Wp = 270n; Wpc = 540n; Wt = 540n
  Temperature: 27
  Analysis tran: stop=5n
  Signals: /I48/WEN (terminal), /I48/D7 (terminal), /I48/D6 (terminal), /I48/D5 (terminal), /I48/D4 (terminal), /I48/D3 (terminal), /I48/D2 (terminal), /I48/D1 (terminal), /I48/D0 (terminal), /I48/WLR<0> (terminal), /I48/CS<0> (terminal), /I48/Clk (terminal), /I48/VDD (terminal), /I48/Gnd (terminal)
Run mode: Single Run, Sweeps and Corners
