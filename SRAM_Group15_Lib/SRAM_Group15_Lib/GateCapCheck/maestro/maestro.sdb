ADE simulation setup
Run mode: Single Run, Sweeps and Corners
Tests:
  SRAM_Group15_Lib_GateCapCheck_1: SRAM_Group15_Lib/GateCapCheck/schematic, simulator spectre
    Outputs: Crise; Cfall; Cavg
