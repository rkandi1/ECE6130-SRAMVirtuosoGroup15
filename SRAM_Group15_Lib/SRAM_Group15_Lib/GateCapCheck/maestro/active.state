ADE simulation setup
Test SRAM_Group15_Lib_GateCapCheck_1: SRAM_Group15_Lib/GateCapCheck/schematic, simulator spectre
  Models: /nethome/rkandi3/ECE6130_Updated/ECE6130_LAB/Hspice/INC/NMOS_THKOX.inc, /nethome/rkandi3/ECE6130_Updated/ECE6130_LAB/Hspice/INC/NMOS_VTG.inc, /nethome/rkandi3/ECE6130_Updated/ECE6130_LAB/Hspice/INC/NMOS_VTH.inc, /nethome/rkandi3/ECE6130_Updated/ECE6130_LAB/Hspice/INC/NMOS_VTL.inc, /nethome/rkandi3/ECE6130_Updated/ECE6130_LAB/Hspice/INC/PMOS_THKOX.inc, /nethome/rkandi3/ECE6130_Updated/ECE6130_LAB/Hspice/INC/PMOS_VTG.inc, /nethome/rkandi3/ECE6130_Updated/ECE6130_LAB/Hspice/INC/PMOS_VTH.inc, /nethome/rkandi3/ECE6130_Updated/ECE6130_LAB/Hspice/INC/PMOS_VTL.inc
  Temperature: 27
  Analysis dc: (saves the operating point)
  Analysis tran: stop=1.2n
  Output Crise = (integ((- IT("/V1/PLUS")) 8e-11 3.5e-10) / 0.8) (unticked)
  Output Cfall = (integ(IT("/V1/PLUS") 4.8e-10 7.5e-10) / 0.8) (unticked)
  Output Cavg = ((Crise + Cfall) / 2) (unticked)
  Signals: /net1, /V1/MINUS (terminal), /V1/PLUS (terminal)
Run mode: Single Run, Sweeps and Corners
