ADE simulation setup
Run mode: Single Run, Sweeps and Corners
Tests:
  SRAM_Group15_Lib_SRAM_Bit_Cell_TB_1: SRAM_Group15_Lib/SRAM_Bit_Cell_TB/schematic, simulator spectre
    Variables: S1 = 1.5; S2 = 2; vin = 0; W = 90n
