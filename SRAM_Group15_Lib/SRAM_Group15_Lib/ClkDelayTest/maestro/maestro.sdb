ADE simulation setup
Run mode: Single Run, Sweeps and Corners
Tests:
  SRAM_Group15_Lib_ClkDelayTest_1: SRAM_Group15_Lib/ClkDelayTest/schematic, simulator spectre
