ADE simulation setup
Run mode: Single Run, Sweeps and Corners
Tests:
  SRAM_Group15_Lib_test_write_circuit_1: SRAM_Group15_Lib/test_write_circuit/schematic, simulator spectre
    Variables: vsup = 0.6:0.05:0.8
    Outputs: Enable_Delay; Write_Time_0; Lowest_BL_0; Write_Time_1; Lowest_BLB_1; Power_V0_Active; Power_Precharge; Power_V0_Idle; Precharge Delay
