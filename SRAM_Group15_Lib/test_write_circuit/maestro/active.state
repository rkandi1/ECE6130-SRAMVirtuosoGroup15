ADE simulation setup
Test SRAM_Group15_Lib_test_write_circuit_1: SRAM_Group15_Lib/test_write_circuit/schematic, simulator spectre
  Models: /nethome/shossain49/ECE6130_Updated/ECE6130_LAB/Hspice/INC/NMOS_THKOX.inc, /nethome/shossain49/ECE6130_Updated/ECE6130_LAB/Hspice/INC/NMOS_VTG.inc, /nethome/shossain49/ECE6130_Updated/ECE6130_LAB/Hspice/INC/NMOS_VTH.inc, /nethome/shossain49/ECE6130_Updated/ECE6130_LAB/Hspice/INC/NMOS_VTL.inc, /nethome/shossain49/ECE6130_Updated/ECE6130_LAB/Hspice/INC/PMOS_THKOX.inc, /nethome/shossain49/ECE6130_Updated/ECE6130_LAB/Hspice/INC/PMOS_VTG.inc, /nethome/shossain49/ECE6130_Updated/ECE6130_LAB/Hspice/INC/PMOS_VTH.inc, /nethome/shossain49/ECE6130_Updated/ECE6130_LAB/Hspice/INC/PMOS_VTL.inc
  Variables: vsup = 0.8
  Temperature: 27
  Analysis tran: stop=4n maxstep=2p
  Output Enable_Delay = (cross(VT("/I0/net3") (VAR("vsup") / 2) 1 "falling") - cross(VT("/CLK") (VAR("vsup") / 2) 1 "rising"))
  Output Write_Time_0 = (cross(VT("/BL<0>") (0.4 * VAR("vsup")) 1 "falling") - cross(VT("/S0") (VAR("vsup") / 2) 1 "rising"))
  Output Lowest_BL_0 = (value(VT("/BL<0>") 1.525e-09) / VAR("vsup"))
  Output Write_Time_1 = (cross(VT("/BLB<0>") (0.4 * VAR("vsup")) 1 "falling") - cross(VT("/S0") (VAR("vsup") / 2) 2 "rising"))
  Output Lowest_BLB_1 = (value(VT("/BLB<0>") 2.525e-09) / VAR("vsup"))
  Output Power_V0_Active = (average(clip((- IT("/V0/PLUS")) 1e-09 3e-09)) * VAR("vsup"))
  Output Power_Precharge = ((average(clip((- IT("/V6/PLUS")) 1e-09 3e-09)) + average(clip((- IT("/V7/PLUS")) 1e-09 3e-09))) * VAR("vsup"))
  Output Power_V0_Idle = (average(clip((- IT("/V0/PLUS")) 3e-09 4e-09)) * VAR("vsup"))
  Output Precharge Delay = (cross(VT("/BL<0>") (0.9 * VAR("vsup")) 1 "rising") - cross(VT("/CLK") (0.5 * VAR("vsup")) 1 "falling"))
  Signals: /CLK, /S0, /BL<0>, /BLB<0>, /I0/net3, /V0/PLUS (terminal), /V6/PLUS (terminal), /V7/PLUS (terminal)
Run mode: Single Run, Sweeps and Corners
Setup values for test SRAM_Group15_Lib_test_write_circuit_1: vsup = 0.6:0.05:0.8
