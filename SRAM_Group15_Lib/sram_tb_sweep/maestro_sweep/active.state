ADE simulation setup
Test SRAM_Group15_Lib_sram_tb_sweep_1: SRAM_Group15_Lib/sram_tb_sweep/schematic, simulator spectre
  Models: /nethome/lgelin3/ECE6130_Updated/ECE6130_LAB/Hspice/INC/NMOS_THKOX.inc, /nethome/lgelin3/ECE6130_Updated/ECE6130_LAB/Hspice/INC/NMOS_VTG.inc, /nethome/lgelin3/ECE6130_Updated/ECE6130_LAB/Hspice/INC/NMOS_VTH.inc, /nethome/lgelin3/ECE6130_Updated/ECE6130_LAB/Hspice/INC/NMOS_VTL.inc, /nethome/lgelin3/ECE6130_Updated/ECE6130_LAB/Hspice/INC/PMOS_THKOX.inc, /nethome/lgelin3/ECE6130_Updated/ECE6130_LAB/Hspice/INC/PMOS_VTG.inc, /nethome/lgelin3/ECE6130_Updated/ECE6130_LAB/Hspice/INC/PMOS_VTH.inc, /nethome/lgelin3/ECE6130_Updated/ECE6130_LAB/Hspice/INC/PMOS_VTL.inc
  Variables: thold = 725p; tsu = 250p 180p 150p 130p 115p 100p 90p 80p 70p 60p 50p; fclk = 1e9; VDD = 0.7 0.8 0.9 1.0; per = 1/fclk; tr = 0.05*per
  Temperature: 27
  Analysis tran: stop=4n
  Output Ptotal = (VAR("VDD") * average(clip(IT("/I1/VDD") (1 / VAR("fclk")) (4 / VAR("fclk")))))
  Output tCLK_WL = (cross(VT("/WL5") (VAR("VDD") / 2) 1 "rising") - cross(VT("/CLK") (VAR("VDD") / 2) 2 "rising")) (unticked)
  Output p_vs_delay = waveVsWave(?x tCLK_WL ?y Ptotal) (unticked)
  Output tclkq = (cross(VT("/I1/net13") (VAR("VDD") / 2) 1 "rising") - cross(VT("/CLK") (VAR("VDD") / 2) 2 "rising"))
  Output preg = (VAR("VDD") * average(clip(IT("/I1/I0/VDD") (1 / VAR("fclk")) (4 / VAR("fclk"))))) (unticked)
  Output p_vs_clkq = waveVsWave(?x tclkq ?y preg)
  Output Q_A0 = VT("/I1/net13") (unticked)
  Output IND1 = (cross(VT("/WL5") (VAR("VDD") / 2) 1 "rising") - cross(VT("/I1/net13") (VAR("VDD") / 2) 1 "rising")) (unticked)
  Output Pdec = (Ptotal - preg) (unticked)
  Output p_vs_dec = waveVsWave(?x IND1 ?y Pdec) (unticked)
  Output Q_end = value(VT("/I1/net13") (2.9 / VAR("fclk"))) (unticked)
  Signals: /CLK as CLK, /WL5 as WL5, /I1/I0/VDD (terminal), /I1/net13
Run mode: Single Run, Sweeps and Corners
