ADE simulation setup
Run mode: Single Run, Sweeps and Corners
Tests:
  SRAM_Group15_Lib_sram_tb_sweep_1: SRAM_Group15_Lib/sram_tb_sweep/schematic, simulator spectre
    Variables: per = 1/fclk; tr = 0.05*per; VDD = 0.7 0.8 0.9 1.0; fclk = 1e9; tsu = 250p 180p 150p 130p 115p 100p 90p 80p 70p 60p 50p; thold = 725p
    Outputs: Ptotal; tCLK_WL; p_vs_delay; tclkq; preg; p_vs_clkq; Q_A0; IND1; Pdec; p_vs_dec; Q_end
