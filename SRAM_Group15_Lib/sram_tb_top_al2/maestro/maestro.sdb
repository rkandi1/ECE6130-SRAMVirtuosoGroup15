ADE simulation setup
Run mode: Single Run, Sweeps and Corners
Tests:
  SRAM_Group15_Lib_sram_tb_top_al_1: SRAM_Group15_Lib/sram_tb_top_al/schematic, simulator spectre
    Variables: C = 2.3; S1 = 1.5; S2 = 2; W = 90n; mm = 0; Win = 540n; Wn = 360n; Wp = 360n; Wpc = 180n; Wt = 720n
