ADE simulation setup
Run mode: Single Run, Sweeps and Corners
Tests:
  SRAM_Group15_Lib_WLTest_1: SRAM_Group15_Lib/WLTest/schematic, simulator spectre
    Variables: C = 2.3
